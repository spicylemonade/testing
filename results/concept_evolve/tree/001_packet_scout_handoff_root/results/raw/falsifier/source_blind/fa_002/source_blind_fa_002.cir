* Auto-generated by tools/run_h1_falsifier.py
* case_id=fa_002
* attack_class=source_collapse_mixed
* polarity_mode=mixed
* voltage_mv=50
* voc_a_mv=50
* voc_b_mv=50
* ramp_mvps=10
* ratio_b_to_a=20
* t_stop_s=6.25
* tran_step_s=0.00078125
* R_LOAD=1meg
* T_COLLAPSE_A=4.4
* COLLAPSE_SCALE_A=0.05
* Source-blind ablation of the packet-scout H1 topology.

.include "/home/archivara/work/repo/results/concept_evolve/tree/001_packet_scout_handoff_root/netlists/shared/source_pair_models.inc"
.include "/home/archivara/work/repo/results/concept_evolve/tree/001_packet_scout_handoff_root/netlists/shared/startup_cells.inc"
.include "/home/archivara/work/repo/results/concept_evolve/tree/001_packet_scout_handoff_root/netlists/shared/packet_scout_blocks.inc"

.param VLEVEL=50m
.param VOC_A=50m
.param VOC_B=50m
.param R_UNIT=1k
.param RATIO=20
.param R_A=1000.0
.param R_B=20000.0
.param POL_A=1
.param POL_B=-1
.param RAMP_MVPS=10
.param C_STORE=10u
.param V_HANDOFF=1.2
.param V_HANDOFF_FALL=1.0
.param TSTOP=6.25

.param R_LOAD=1meg
.param T_COLLAPSE_A=4.4
.param COLLAPSE_SCALE_A=0.05

VMEAS_A src_a_p n_src_a_p 0
VMEAS_B src_b_p n_src_b_p 0
XSOURCES src_a_p n_src_a_n src_b_p n_src_b_n source_pair

BMON_A n_src_a 0 V = { V(n_src_a_p,n_src_a_n) }
BMON_B n_src_b 0 V = { V(n_src_b_p,n_src_b_n) }
RREF_A n_src_a_n 0 1g
RREF_B n_src_b_n 0 1g

XROUTE_A n_src_a_p n_src_a_n n_a_bus_p n_a_bus_n fw_router
XROUTE_B n_src_b_p n_src_b_n n_b_bus_p n_b_bus_n fw_router

VCTRL_MON n_store n_ctrl 0
XCORE n_a_bus_p n_a_bus_n n_b_bus_p n_b_bus_n n_store n_ctrl n_handoff source_blind_packet_gate

CSTORE n_store 0 {C_STORE} ic=0
RLOAD n_store 0 100meg

.include "/home/archivara/work/repo/results/concept_evolve/tree/001_packet_scout_handoff_root/netlists/shared/measurement_hooks.inc"

.tran 0.00078125 6.25 0 0.00078125
.end
