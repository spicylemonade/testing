* Champion H1 topology: RC-ranked packet gate.

.include "/home/archivara/work/repo/results/concept_evolve/tree/001_packet_scout_handoff_root/netlists/shared/source_pair_models.inc"
.include "/home/archivara/work/repo/results/concept_evolve/tree/001_packet_scout_handoff_root/netlists/shared/startup_cells.inc"
.include "/home/archivara/work/repo/results/concept_evolve/tree/001_packet_scout_handoff_root/netlists/shared/packet_scout_blocks.inc"

.param VLEVEL=300m
.param VOC_A={VLEVEL}
.param VOC_B={VLEVEL}
.param R_UNIT=1k
.param RATIO=1
.param R_A=1000.0
.param R_B=1000.0
.param POL_A=1
.param POL_B=-1
.param RAMP_MVPS=10
.param C_STORE=10u
.param R_LOAD=100meg
.param V_HANDOFF=1.2
.param V_HANDOFF_FALL=1.0
.param TSTOP=37.5

.param R_LOAD=50k
.param T_COLLAPSE_A=4.6
.param T_RECOVER_A=6.0
.param COLLAPSE_SCALE_A=0.0
.param T_COLLAPSE_B=4.8
.param COLLAPSE_SCALE_B=0.0

VMEAS_A src_a_p n_src_a_p 0
VMEAS_B src_b_p n_src_b_p 0
XSOURCES src_a_p n_src_a_n src_b_p n_src_b_n source_pair

BMON_A n_src_a 0 V = { V(n_src_a_p,n_src_a_n) }
BMON_B n_src_b 0 V = { V(n_src_b_p,n_src_b_n) }
RREF_A n_src_a_n 0 1g
RREF_B n_src_b_n 0 1g

XROUTE_A n_src_a_p n_src_a_n n_a_bus_p n_a_bus_n fw_router
XROUTE_B n_src_b_p n_src_b_n n_b_bus_p n_b_bus_n fw_router

VCTRL_MON n_store n_ctrl 0
XCORE n_a_bus_p n_a_bus_n n_b_bus_p n_b_bus_n n_store n_ctrl n_handoff rc_rank_packet_gate

CSTORE n_store 0 {C_STORE} ic=0
RLOAD n_store 0 {R_LOAD}

BSEEN_DRV seen_drv 0 V = { V(n_handoff) > 0.5 ? 1 : 0 }
DSEEN seen_drv n_seen DSEENMOD
CSEEN n_seen 0 1p ic=0
RSEEN n_seen 0 1e12
.model DSEENMOD D(Is=1e-18 N=1 Rs=1m Cjo=0)
BLATCH latch_gate 0 V = { 0.5 * (1 + tanh(80 * (V(n_seen) - 0.5))) }
BPAWR_A pwr_back_a 0 V = { neg(V(n_src_a_p,n_src_a_n) * I(VMEAS_A)) }
BPAWR_B pwr_back_b 0 V = { neg(V(n_src_b_p,n_src_b_n) * I(VMEAS_B)) }
BPCTRL pwr_ctrl 0 V = { pos(V(n_store) * I(VCTRL_MON)) }
BPAWR_A_PRE pwr_back_a_pre 0 V = { V(pwr_back_a) * (1 - V(latch_gate)) }
BPAWR_B_PRE pwr_back_b_pre 0 V = { V(pwr_back_b) * (1 - V(latch_gate)) }
BPCTRL_PRE pwr_ctrl_pre 0 V = { V(pwr_ctrl) * (1 - V(latch_gate)) }
.measure tran vstore_final find v(n_store) at={TSTOP}
.measure tran t_handoff when v(n_handoff)=0.5 rise=1
.measure tran t_handoff_fall when v(n_handoff)=0.5 fall=1
.measure tran t_handoff_rise2 when v(n_handoff)=0.5 rise=2
.measure tran e_back_a integ v(pwr_back_a_pre) from=0 to={TSTOP}
.measure tran e_back_b integ v(pwr_back_b_pre) from=0 to={TSTOP}
.measure tran e_backdrive param='e_back_a + e_back_b'
.measure tran e_ctrl integ v(pwr_ctrl_pre) from=0 to={TSTOP}
.measure tran e_backdrive_full integ v(pwr_back_a) from=0 to={TSTOP}
.measure tran e_ctrl_full integ v(pwr_ctrl) from=0 to={TSTOP}
.measure tran startup_ok param='(vstore_final >= V_HANDOFF)'
.tran 0.0046875 37.5 0 0.0046875
.end
