* Champion H1 topology: RC-ranked packet gate.

.include "/home/archivara/work/repo/results/concept_evolve/tree/001_packet_scout_handoff_root/netlists/shared/source_pair_models.inc"
.include "/home/archivara/work/repo/results/concept_evolve/tree/001_packet_scout_handoff_root/netlists/shared/startup_cells.inc"
.include "/home/archivara/work/repo/results/concept_evolve/tree/001_packet_scout_handoff_root/netlists/shared/packet_scout_blocks.inc"

.param VLEVEL=100m
.param VOC_A=100m
.param VOC_B=100m
.param R_UNIT=1k
.param RATIO=1
.param R_A=1000.0
.param R_B=1000.0
.param POL_A=1
.param POL_B=1
.param RAMP_MVPS=10
.param C_STORE=10u
.param R_LOAD=100meg
.param V_HANDOFF=1.2
.param V_HANDOFF_FALL=1.0
.param TSTOP=12.5

.param R_LOAD=40k
.param C_STORE=5u
.param T_COLLAPSE_A=5.4
.param T_RECOVER_A=7.0
.param COLLAPSE_SCALE_A=0.0
.param T_COLLAPSE_B=5.6000000000000005
.param T_RECOVER_B=7.3
.param COLLAPSE_SCALE_B=0.0
.param T_COLLAPSE_EDGE=0.2

VMEAS_A src_a_p n_src_a_p 0
VMEAS_B src_b_p n_src_b_p 0
XSOURCES src_a_p n_src_a_n src_b_p n_src_b_n source_pair

BMON_A n_src_a 0 V = { V(n_src_a_p,n_src_a_n) }
BMON_B n_src_b 0 V = { V(n_src_b_p,n_src_b_n) }
RREF_A n_src_a_n 0 1g
RREF_B n_src_b_n 0 1g

XROUTE_A n_src_a_p n_src_a_n n_a_bus_p n_a_bus_n fw_router
XROUTE_B n_src_b_p n_src_b_n n_b_bus_p n_b_bus_n fw_router

VCTRL_MON n_store n_ctrl 0
XCORE n_a_bus_p n_a_bus_n n_b_bus_p n_b_bus_n n_store n_ctrl n_handoff rc_rank_packet_gate

CSTORE n_store 0 {C_STORE} ic=0
RLOAD n_store 0 {R_LOAD}

.include "/home/archivara/work/repo/results/concept_evolve/tree/001_packet_scout_handoff_root/netlists/shared/measurement_hooks.inc"

.tran 0.0015625 12.5 0 0.0015625
.end
