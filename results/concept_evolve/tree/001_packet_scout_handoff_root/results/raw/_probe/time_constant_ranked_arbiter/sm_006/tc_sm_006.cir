* Champion H1 topology: RC-ranked packet gate.

.include "/home/archivara/work/repo/results/concept_evolve/tree/001_packet_scout_handoff_root/netlists/shared/source_pair_models.inc"
.include "/home/archivara/work/repo/results/concept_evolve/tree/001_packet_scout_handoff_root/netlists/shared/startup_cells.inc"

.param TC_FAST_R=30k
.param TC_FAST_C=1.5n
.param TC_SLOW_R=220k
.param TC_SLOW_C=7n
.param TC_GAIN=26
.param TC_TIE=6
.param G_TC_CTRL=18n

.subckt time_constant_ranked_arbiter a_p a_n b_p b_n n_store n_ctrl n_handoff
EOBS_A a_obs 0 VALUE = { V(a_p,a_n) }
RFAST_A a_obs a_fast {TC_FAST_R}
CFAST_A a_fast 0 {TC_FAST_C}
RSLOW_A a_obs a_slow {TC_SLOW_R}
CSLOW_A a_slow 0 {TC_SLOW_C}

EOBS_B b_obs 0 VALUE = { V(b_p,b_n) }
RFAST_B b_obs b_fast {TC_FAST_R}
CFAST_B b_fast 0 {TC_FAST_C}
RSLOW_B b_obs b_slow {TC_SLOW_R}
CSLOW_B b_slow 0 {TC_SLOW_C}

BRANK_A rank_a 0 V = { V(a_fast) - V(a_slow) }
BRANK_B rank_b 0 V = { V(b_fast) - V(b_slow) }
BSEL_A sel_a 0 V = { 0.5 * (1 + tanh(TC_GAIN * ((V(rank_a) - V(rank_b)) + TC_TIE * (V(a_fast) - V(b_fast))))) }
BSEL_B sel_b 0 V = { 1 - V(sel_a) }

BIN_A a_p a_n I = { G_PUMP * pos(V(a_p,a_n) - VSTART_DEAD) * V(sel_a) }
BIN_B b_p b_n I = { G_PUMP * pos(V(b_p,b_n) - VSTART_DEAD) * V(sel_b) }
BSTORE_A 0 n_store I = { ETA_PUMP * G_PUMP * pos(V(a_p,a_n) - VSTART_DEAD) * V(sel_a) }
BSTORE_B 0 n_store I = { ETA_PUMP * G_PUMP * pos(V(b_p,b_n) - VSTART_DEAD) * V(sel_b) }
BCTRL_TC n_ctrl 0 I = { G_TC_CTRL * V(n_ctrl) }
BHANDOFF n_handoff 0 V = { V(n_store) >= V_HANDOFF ? 1 : 0 }
.ends time_constant_ranked_arbiter
.param VLEVEL=50m
.param VOC_A={VLEVEL}
.param VOC_B={VLEVEL}
.param R_UNIT=1k
.param RATIO=20
.param R_A=1000.0
.param R_B=20000.0
.param POL_A=1
.param POL_B=1
.param RAMP_MVPS=1
.param C_STORE=10u
.param R_LOAD=100meg
.param V_HANDOFF=1.2
.param V_HANDOFF_FALL=1.0
.param TSTOP=62.5

VMEAS_A src_a_p n_src_a_p 0
VMEAS_B src_b_p n_src_b_p 0
XSOURCES src_a_p n_src_a_n src_b_p n_src_b_n source_pair

BMON_A n_src_a 0 V = { V(n_src_a_p,n_src_a_n) }
BMON_B n_src_b 0 V = { V(n_src_b_p,n_src_b_n) }
RREF_A n_src_a_n 0 1g
RREF_B n_src_b_n 0 1g

XROUTE_A n_src_a_p n_src_a_n n_a_bus_p n_a_bus_n fw_router
XROUTE_B n_src_b_p n_src_b_n n_b_bus_p n_b_bus_n fw_router

VCTRL_MON n_store n_ctrl 0
XCORE n_a_bus_p n_a_bus_n n_b_bus_p n_b_bus_n n_store n_ctrl n_handoff time_constant_ranked_arbiter

CSTORE n_store 0 {C_STORE} ic=0
RLOAD n_store 0 {R_LOAD}

.include "/home/archivara/work/repo/results/concept_evolve/tree/001_packet_scout_handoff_root/netlists/shared/measurement_hooks.inc"

.tran 0.0078125 62.5 0 0.0078125
.end
