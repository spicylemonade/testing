* Auto-generated by tools/run_h1_falsifier.py
* case_id=fa_005
* attack_class=mixed_polarity_conflict
* polarity_mode=mixed
* voltage_mv=300
* voc_a_mv=300
* voc_b_mv=300
* ramp_mvps=10
* ratio_b_to_a=1
* t_stop_s=37.5
* tran_step_s=0.0046875
* R_LOAD=50k
* T_COLLAPSE_A=4.66211
* T_RECOVER_A=5.86853
* COLLAPSE_SCALE_A=0
* T_COLLAPSE_B=4.90475
* COLLAPSE_SCALE_B=0.0294498
* C_STORE=9.27281e-06
* VSTART_DEAD=0.00460592
* TC_FAST_R=31215.1
* TC_FAST_C=1.69616e-09
* TC_SLOW_R=268483
* TC_SLOW_C=5.48937e-09
* G_TC_CTRL=1.49752e-08
* Lower-overhead time-constant-ranked arbiter for H1_multisource_cold_start.

.include "/home/archivara/work/repo/results/concept_evolve/tree/001_packet_scout_handoff_root/netlists/shared/source_pair_models.inc"
.include "/home/archivara/work/repo/results/concept_evolve/tree/001_packet_scout_handoff_root/netlists/shared/startup_cells.inc"
.include "/home/archivara/work/repo/results/concept_evolve/tree/001_packet_scout_handoff_root/netlists/shared/packet_scout_blocks.inc"

.param VLEVEL=300m
.param VOC_A=300m
.param VOC_B=300m
.param R_UNIT=1k
.param RATIO=1
.param R_A=1019.656353
.param R_B=1038.819066
.param POL_A=1
.param POL_B=-1
.param RAMP_MVPS=10
.param C_STORE=10u
.param R_LOAD=100meg
.param V_HANDOFF=1.2
.param V_HANDOFF_FALL=1.0
.param TSTOP=37.5

.param R_LOAD=50k
.param T_COLLAPSE_A=4.66211
.param T_RECOVER_A=5.86853
.param COLLAPSE_SCALE_A=0
.param T_COLLAPSE_B=4.90475
.param COLLAPSE_SCALE_B=0.0294498
.param C_STORE=9.27281e-06
.param VSTART_DEAD=0.00460592
.param TC_FAST_R=31215.1
.param TC_FAST_C=1.69616e-09
.param TC_SLOW_R=268483
.param TC_SLOW_C=5.48937e-09
.param G_TC_CTRL=1.49752e-08

VMEAS_A src_a_p n_src_a_p 0
VMEAS_B src_b_p n_src_b_p 0
XSOURCES src_a_p n_src_a_n src_b_p n_src_b_n source_pair

BMON_A n_src_a 0 V = { V(n_src_a_p,n_src_a_n) }
BMON_B n_src_b 0 V = { V(n_src_b_p,n_src_b_n) }
RREF_A n_src_a_n 0 1g
RREF_B n_src_b_n 0 1g

XROUTE_A n_src_a_p n_src_a_n n_a_bus_p n_a_bus_n fw_router
XROUTE_B n_src_b_p n_src_b_n n_b_bus_p n_b_bus_n fw_router

VCTRL_MON n_store n_ctrl 0
XCORE n_a_bus_p n_a_bus_n n_b_bus_p n_b_bus_n n_store n_ctrl n_handoff time_constant_ranked_arbiter

CSTORE n_store 0 {C_STORE} ic=0
RLOAD n_store 0 {R_LOAD}

.include "/home/archivara/work/repo/results/concept_evolve/tree/001_packet_scout_handoff_root/netlists/shared/measurement_hooks.inc"

.tran 0.0046875 37.5 0 0.0046875
.end
