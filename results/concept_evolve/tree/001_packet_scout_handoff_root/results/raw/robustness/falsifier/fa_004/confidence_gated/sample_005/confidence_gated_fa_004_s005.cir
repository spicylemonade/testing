* Auto-generated by tools/run_h1_falsifier.py
* case_id=fa_004
* attack_class=uvlo_chatter_same_window
* polarity_mode=same
* voltage_mv=100
* voc_a_mv=100
* voc_b_mv=100
* ramp_mvps=10
* ratio_b_to_a=1
* t_stop_s=18.0
* tran_step_s=0.001
* V_HANDOFF=0.8
* V_HANDOFF_FALL=0.7
* R_LOAD=100k
* C_STORE=8.17287e-06
* T_COLLAPSE_A=10.7512
* T_RECOVER_A=15.0269
* COLLAPSE_SCALE_A=0.0760122
* T_COLLAPSE_B=10.6968
* T_RECOVER_B=15.0076
* COLLAPSE_SCALE_B=0.0309248
* T_COLLAPSE_EDGE=0.02
* VSTART_DEAD=0.00507959
* SCOUT_R=145493
* SCOUT_C=4.33218e-09
* G_SCOUT_CTRL=4.22518e-08
* CONF_EPS=0.00104788
* CONF_AMP_FLOOR=0.00998778
* CONF_R=96198.5
* CONF_C=5.38614e-07
* G_CONF_CTRL=8.15575e-09
* DEEPEN variant: confidence-gated abstention on the packet scaffold.

.include "/home/archivara/work/repo/results/concept_evolve/tree/001_packet_scout_handoff_root/netlists/shared/source_pair_models.inc"
.include "/home/archivara/work/repo/results/concept_evolve/tree/001_packet_scout_handoff_root/netlists/shared/startup_cells.inc"
.include "/home/archivara/work/repo/results/concept_evolve/tree/001_packet_scout_handoff_root/netlists/shared/packet_scout_blocks.inc"

.param VLEVEL=100m
.param VOC_A=100m
.param VOC_B=100m
.param R_UNIT=1k
.param RATIO=1
.param R_A=960.170649
.param R_B=937.964696
.param POL_A=1
.param POL_B=1
.param RAMP_MVPS=10
.param C_STORE=10u
.param R_LOAD=100meg
.param V_HANDOFF=1.2
.param V_HANDOFF_FALL=1.0
.param TSTOP=18.0

.param V_HANDOFF=0.8
.param V_HANDOFF_FALL=0.7
.param R_LOAD=100k
.param C_STORE=8.17287e-06
.param T_COLLAPSE_A=10.7512
.param T_RECOVER_A=15.0269
.param COLLAPSE_SCALE_A=0.0760122
.param T_COLLAPSE_B=10.6968
.param T_RECOVER_B=15.0076
.param COLLAPSE_SCALE_B=0.0309248
.param T_COLLAPSE_EDGE=0.02
.param VSTART_DEAD=0.00507959
.param SCOUT_R=145493
.param SCOUT_C=4.33218e-09
.param G_SCOUT_CTRL=4.22518e-08
.param CONF_EPS=0.00104788
.param CONF_AMP_FLOOR=0.00998778
.param CONF_R=96198.5
.param CONF_C=5.38614e-07
.param G_CONF_CTRL=8.15575e-09

VMEAS_A src_a_p n_src_a_p 0
VMEAS_B src_b_p n_src_b_p 0
XSOURCES src_a_p n_src_a_n src_b_p n_src_b_n source_pair

BMON_A n_src_a 0 V = { V(n_src_a_p,n_src_a_n) }
BMON_B n_src_b 0 V = { V(n_src_b_p,n_src_b_n) }
RREF_A n_src_a_n 0 1g
RREF_B n_src_b_n 0 1g

XROUTE_A n_src_a_p n_src_a_n n_a_bus_p n_a_bus_n fw_router
XROUTE_B n_src_b_p n_src_b_n n_b_bus_p n_b_bus_n fw_router

VCTRL_MON n_store n_ctrl 0
XCORE n_a_bus_p n_a_bus_n n_b_bus_p n_b_bus_n n_store n_ctrl n_handoff n_conf n_commit confidence_gated_packet_gate

CSTORE n_store 0 {C_STORE} ic=0
RLOAD n_store 0 {R_LOAD}

.include "/home/archivara/work/repo/results/concept_evolve/tree/001_packet_scout_handoff_root/netlists/shared/measurement_hooks.inc"

.measure tran t_commit when v(n_commit)=0.5 rise=1
.measure tran conf_final find v(n_conf) at={TSTOP}

.tran 0.001 18.0 0 0.001
.end
