* Auto-generated by tools/run_h1_falsifier.py
* case_id=fa_004
* attack_class=uvlo_chatter_same_window
* polarity_mode=same
* voltage_mv=100
* voc_a_mv=100
* voc_b_mv=100
* ramp_mvps=10
* ratio_b_to_a=1
* t_stop_s=18.0
* tran_step_s=0.001
* V_HANDOFF=0.8
* V_HANDOFF_FALL=0.7
* R_LOAD=100k
* C_STORE=1.27965e-05
* T_COLLAPSE_A=10.671
* T_RECOVER_A=14.9642
* COLLAPSE_SCALE_A=0
* T_COLLAPSE_B=10.5144
* T_RECOVER_B=15.0709
* COLLAPSE_SCALE_B=0
* T_COLLAPSE_EDGE=0.02
* VSTART_DEAD=0.00596009
* Non-source-aware multi-input startup baseline for H1_multisource_cold_start.

.include "/home/archivara/work/repo/results/concept_evolve/tree/001_packet_scout_handoff_root/netlists/shared/source_pair_models.inc"
.include "/home/archivara/work/repo/results/concept_evolve/tree/001_packet_scout_handoff_root/netlists/shared/startup_cells.inc"

.param VLEVEL=100m
.param VOC_A=100m
.param VOC_B=100m
.param R_UNIT=1k
.param RATIO=1
.param R_A=1002.853914
.param R_B=910.189301
.param POL_A=1
.param POL_B=1
.param RAMP_MVPS=10
.param C_STORE=10u
.param R_LOAD=100meg
.param V_HANDOFF=1.2
.param V_HANDOFF_FALL=1.0
.param TSTOP=18.0

.param V_HANDOFF=0.8
.param V_HANDOFF_FALL=0.7
.param R_LOAD=100k
.param C_STORE=1.27965e-05
.param T_COLLAPSE_A=10.671
.param T_RECOVER_A=14.9642
.param COLLAPSE_SCALE_A=0
.param T_COLLAPSE_B=10.5144
.param T_RECOVER_B=15.0709
.param COLLAPSE_SCALE_B=0
.param T_COLLAPSE_EDGE=0.02
.param VSTART_DEAD=0.00596009

VMEAS_A src_a_p n_src_a_p 0
VMEAS_B src_b_p n_src_b_p 0
XSOURCES src_a_p n_src_a_n src_b_p n_src_b_n source_pair

BMON_A n_src_a 0 V = { V(n_src_a_p,n_src_a_n) }
BMON_B n_src_b 0 V = { V(n_src_b_p,n_src_b_n) }
RANCHOR_A n_src_a_p n_src_a_n 1g
RANCHOR_B n_src_b_p n_src_b_n 1g
RREF_A n_src_a_n 0 1g
RREF_B n_src_b_n 0 1g

XROUTE_A n_src_a_p n_src_a_n n_a_bus_p n_a_bus_n fw_router
XROUTE_B n_src_b_p n_src_b_n n_b_bus_p n_b_bus_n fw_router

RJOIN_A_P n_a_bus_p n_start_p 1m
RJOIN_A_N n_a_bus_n n_start_n 1m
RJOIN_B_P n_b_bus_p n_start_p 1m
RJOIN_B_N n_b_bus_n n_start_n 1m

XSTARTUP n_start_p n_start_n n_store n_handoff startup_pump

VCTRL_MON n_store n_ctrl 0
RCTRL_OSC n_ctrl 0 40meg
RCTRL_PATH_A n_ctrl 0 80meg
RCTRL_PATH_B n_ctrl 0 80meg

CSTORE n_store 0 {C_STORE} ic=0
RLOAD n_store 0 {R_LOAD}

.include "/home/archivara/work/repo/results/concept_evolve/tree/001_packet_scout_handoff_root/netlists/shared/measurement_hooks.inc"

.tran 0.001 18.0 0 0.001
.end
